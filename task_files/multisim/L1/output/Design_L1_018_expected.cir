** Design_L1_018 **
*
* NI Multisim to SPICE Netlist Export
* Generated by: julya
* Tue, Jul 15, 2025 15:20:14
*

*## Multisim Component V1 ##*
vV1 1 2 dc 12 ac 0 0
+           distof1 0 0
+           distof2 0 0

*## Multisim Component R1 ##*
rR1 1 2 1000 vresR1
.model vresR1 r(  )

*## Multisim Instrument XSC1 ##*
